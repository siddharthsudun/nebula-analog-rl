* Receiver 1-tap DFE stage (transient). Node outn = equalized slicer input.
* cursors: c0=-0.505171 V (main), c1=-0.07753 V (first post-cursor); tap=-0.07753
Vb  nb  0 PWL(0.000000e+00 1.00000 1.999000e-10 1.00000 2.000000e-10 1.00000 3.999000e-10 1.00000 4.000000e-10 1.00000 5.999000e-10 1.00000 6.000000e-10 -1.00000 7.999000e-10 -1.00000 8.000000e-10 -1.00000 9.999000e-10 -1.00000 1.000000e-09 -1.00000 1.199900e-09 -1.00000 1.200000e-09 -1.00000 1.399900e-09 -1.00000 1.400000e-09 -1.00000 1.599900e-09 -1.00000 1.600000e-09 -1.00000 1.799900e-09 -1.00000 1.800000e-09 1.00000 1.999900e-09 1.00000 2.000000e-09 1.00000 2.199900e-09 1.00000 2.200000e-09 1.00000 2.399900e-09 1.00000 2.400000e-09 1.00000 2.599900e-09 1.00000 2.600000e-09 1.00000 2.799900e-09 1.00000 2.800000e-09 1.00000 2.999900e-09 1.00000 3.000000e-09 1.00000 3.199900e-09 1.00000 3.200000e-09 1.00000 3.399900e-09 1.00000 3.400000e-09 1.00000 3.599900e-09 1.00000 3.600000e-09 1.00000 3.799900e-09 1.00000 3.800000e-09 1.00000 3.999900e-09 1.00000 4.000000e-09 -1.00000 4.199900e-09 -1.00000 4.200000e-09 1.00000 4.399900e-09 1.00000 4.400000e-09 1.00000 4.599900e-09 1.00000 4.600000e-09 -1.00000 4.799900e-09 -1.00000 4.800000e-09 -1.00000 4.999900e-09 -1.00000 5.000000e-09 1.00000 5.199900e-09 1.00000 5.200000e-09 1.00000 5.399900e-09 1.00000 5.400000e-09 -1.00000 5.599900e-09 -1.00000 5.600000e-09 1.00000 5.799900e-09 1.00000 5.800000e-09 1.00000 5.999900e-09 1.00000 6.000000e-09 1.00000 6.199900e-09 1.00000 6.200000e-09 -1.00000 6.399900e-09 -1.00000 6.400000e-09 -1.00000 6.599900e-09 -1.00000 6.600000e-09 1.00000 6.799900e-09 1.00000 6.800000e-09 -1.00000 6.999900e-09 -1.00000 7.000000e-09 1.00000 7.199900e-09 1.00000 7.200000e-09 -1.00000 7.399900e-09 -1.00000 7.400000e-09 -1.00000 7.599900e-09 -1.00000 7.600000e-09 -1.00000 7.799900e-09 -1.00000 7.800000e-09 -1.00000 7.999900e-09 -1.00000 8.000000e-09 -1.00000 8.199900e-09 -1.00000 8.200000e-09 -1.00000 8.399900e-09 -1.00000 8.400000e-09 -1.00000 8.599900e-09 -1.00000 8.600000e-09 -1.00000 8.799900e-09 -1.00000 8.800000e-09 -1.00000 8.999900e-09 -1.00000 9.000000e-09 1.00000 9.199900e-09 1.00000 9.200000e-09 1.00000 9.399900e-09 1.00000 9.400000e-09 1.00000 9.599900e-09 1.00000 9.600000e-09 -1.00000 9.799900e-09 -1.00000 9.800000e-09 1.00000 9.999900e-09 1.00000 1.000000e-08 1.00000 1.019990e-08 1.00000 1.020000e-08 -1.00000 1.039990e-08 -1.00000 1.040000e-08 -1.00000 1.059990e-08 -1.00000 1.060000e-08 1.00000 1.079990e-08 1.00000 1.080000e-08 1.00000 1.099990e-08 1.00000 1.100000e-08 1.00000 1.119990e-08 1.00000 1.120000e-08 -1.00000 1.139990e-08 -1.00000 1.140000e-08 1.00000 1.159990e-08 1.00000 1.160000e-08 1.00000 1.179990e-08 1.00000 1.180000e-08 1.00000 1.199990e-08 1.00000 1.200000e-08 1.00000 1.219990e-08 1.00000 1.220000e-08 1.00000 1.239990e-08 1.00000 1.240000e-08 1.00000 1.259990e-08 1.00000 1.260000e-08 -1.00000 1.279990e-08 -1.00000 1.280000e-08 1.00000 1.299990e-08 1.00000 1.300000e-08 -1.00000 1.319990e-08 -1.00000 1.320000e-08 1.00000 1.339990e-08 1.00000 1.340000e-08 1.00000 1.359990e-08 1.00000 1.360000e-08 1.00000 1.379990e-08 1.00000 1.380000e-08 1.00000 1.399990e-08 1.00000 1.400000e-08 -1.00000 1.419990e-08 -1.00000 1.420000e-08 -1.00000 1.439990e-08 -1.00000 1.440000e-08 -1.00000 1.459990e-08 -1.00000 1.460000e-08 -1.00000 1.479990e-08 -1.00000 1.480000e-08 1.00000 1.499990e-08 1.00000 1.500000e-08 1.00000 1.519990e-08 1.00000 1.520000e-08 -1.00000 1.539990e-08 -1.00000 1.540000e-08 1.00000 1.559990e-08 1.00000 1.560000e-08 1.00000 1.579990e-08 1.00000 1.580000e-08 -1.00000 1.599990e-08 -1.00000 1.600000e-08 1.00000 1.619990e-08 1.00000 1.620000e-08 1.00000 1.639990e-08 1.00000 1.640000e-08 -1.00000 1.659990e-08 -1.00000 1.660000e-08 -1.00000 1.679990e-08 -1.00000 1.680000e-08 1.00000 1.699990e-08 1.00000 1.700000e-08 1.00000 1.719990e-08 1.00000 1.720000e-08 1.00000 1.739990e-08 1.00000 1.740000e-08 -1.00000 1.759990e-08 -1.00000 1.760000e-08 1.00000 1.779990e-08 1.00000 1.780000e-08 -1.00000 1.799990e-08 -1.00000 1.800000e-08 -1.00000 1.819990e-08 -1.00000 1.820000e-08 1.00000 1.839990e-08 1.00000 1.840000e-08 -1.00000 1.859990e-08 -1.00000 1.860000e-08 -1.00000 1.879990e-08 -1.00000 1.880000e-08 1.00000 1.899990e-08 1.00000 1.900000e-08 1.00000 1.919990e-08 1.00000 1.920000e-08 -1.00000 1.939990e-08 -1.00000 1.940000e-08 -1.00000 1.959990e-08 -1.00000 1.960000e-08 -1.00000 1.979990e-08 -1.00000 1.980000e-08 1.00000 1.999990e-08 1.00000 2.000000e-08 -1.00000 2.019990e-08 -1.00000 2.020000e-08 1.00000 2.039990e-08 1.00000 2.040000e-08 -1.00000 2.059990e-08 -1.00000 2.060000e-08 -1.00000 2.079990e-08 -1.00000 2.080000e-08 1.00000 2.099990e-08 1.00000 2.100000e-08 1.00000 2.119990e-08 1.00000 2.120000e-08 -1.00000 2.139990e-08 -1.00000 2.140000e-08 -1.00000 2.159990e-08 -1.00000 2.160000e-08 1.00000 2.179990e-08 1.00000 2.180000e-08 -1.00000 2.199990e-08 -1.00000 2.200000e-08 1.00000 2.219990e-08 1.00000 2.220000e-08 -1.00000 2.239990e-08 -1.00000 2.240000e-08 1.00000 2.259990e-08 1.00000 2.260000e-08 -1.00000 2.279990e-08 -1.00000 2.280000e-08 1.00000 2.299990e-08 1.00000 2.300000e-08 1.00000 2.319990e-08 1.00000 2.320000e-08 1.00000 2.339990e-08 1.00000 2.340000e-08 -1.00000 2.359990e-08 -1.00000 2.360000e-08 1.00000 2.379990e-08 1.00000 2.380000e-08 -1.00000 2.399990e-08 -1.00000 2.400000e-08 1.00000 2.419990e-08 1.00000 2.420000e-08 -1.00000 2.439990e-08 -1.00000 2.440000e-08 1.00000 2.459990e-08 1.00000 2.460000e-08 -1.00000 2.479990e-08 -1.00000 2.480000e-08 1.00000 2.499990e-08 1.00000 2.500000e-08 -1.00000 2.519990e-08 -1.00000 2.520000e-08 1.00000 2.539990e-08 1.00000 2.540000e-08 1.00000 2.559990e-08 1.00000)
Vbd nbd 0 PWL(0.000000e+00 0.00000 1.999000e-10 0.00000 2.000000e-10 1.00000 3.999000e-10 1.00000 4.000000e-10 1.00000 5.999000e-10 1.00000 6.000000e-10 1.00000 7.999000e-10 1.00000 8.000000e-10 -1.00000 9.999000e-10 -1.00000 1.000000e-09 -1.00000 1.199900e-09 -1.00000 1.200000e-09 -1.00000 1.399900e-09 -1.00000 1.400000e-09 -1.00000 1.599900e-09 -1.00000 1.600000e-09 -1.00000 1.799900e-09 -1.00000 1.800000e-09 -1.00000 1.999900e-09 -1.00000 2.000000e-09 1.00000 2.199900e-09 1.00000 2.200000e-09 1.00000 2.399900e-09 1.00000 2.400000e-09 1.00000 2.599900e-09 1.00000 2.600000e-09 1.00000 2.799900e-09 1.00000 2.800000e-09 1.00000 2.999900e-09 1.00000 3.000000e-09 1.00000 3.199900e-09 1.00000 3.200000e-09 1.00000 3.399900e-09 1.00000 3.400000e-09 1.00000 3.599900e-09 1.00000 3.600000e-09 1.00000 3.799900e-09 1.00000 3.800000e-09 1.00000 3.999900e-09 1.00000 4.000000e-09 1.00000 4.199900e-09 1.00000 4.200000e-09 -1.00000 4.399900e-09 -1.00000 4.400000e-09 1.00000 4.599900e-09 1.00000 4.600000e-09 1.00000 4.799900e-09 1.00000 4.800000e-09 -1.00000 4.999900e-09 -1.00000 5.000000e-09 -1.00000 5.199900e-09 -1.00000 5.200000e-09 1.00000 5.399900e-09 1.00000 5.400000e-09 1.00000 5.599900e-09 1.00000 5.600000e-09 -1.00000 5.799900e-09 -1.00000 5.800000e-09 1.00000 5.999900e-09 1.00000 6.000000e-09 1.00000 6.199900e-09 1.00000 6.200000e-09 1.00000 6.399900e-09 1.00000 6.400000e-09 -1.00000 6.599900e-09 -1.00000 6.600000e-09 -1.00000 6.799900e-09 -1.00000 6.800000e-09 1.00000 6.999900e-09 1.00000 7.000000e-09 -1.00000 7.199900e-09 -1.00000 7.200000e-09 1.00000 7.399900e-09 1.00000 7.400000e-09 -1.00000 7.599900e-09 -1.00000 7.600000e-09 -1.00000 7.799900e-09 -1.00000 7.800000e-09 -1.00000 7.999900e-09 -1.00000 8.000000e-09 -1.00000 8.199900e-09 -1.00000 8.200000e-09 -1.00000 8.399900e-09 -1.00000 8.400000e-09 -1.00000 8.599900e-09 -1.00000 8.600000e-09 -1.00000 8.799900e-09 -1.00000 8.800000e-09 -1.00000 8.999900e-09 -1.00000 9.000000e-09 -1.00000 9.199900e-09 -1.00000 9.200000e-09 1.00000 9.399900e-09 1.00000 9.400000e-09 1.00000 9.599900e-09 1.00000 9.600000e-09 1.00000 9.799900e-09 1.00000 9.800000e-09 -1.00000 9.999900e-09 -1.00000 1.000000e-08 1.00000 1.019990e-08 1.00000 1.020000e-08 1.00000 1.039990e-08 1.00000 1.040000e-08 -1.00000 1.059990e-08 -1.00000 1.060000e-08 -1.00000 1.079990e-08 -1.00000 1.080000e-08 1.00000 1.099990e-08 1.00000 1.100000e-08 1.00000 1.119990e-08 1.00000 1.120000e-08 1.00000 1.139990e-08 1.00000 1.140000e-08 -1.00000 1.159990e-08 -1.00000 1.160000e-08 1.00000 1.179990e-08 1.00000 1.180000e-08 1.00000 1.199990e-08 1.00000 1.200000e-08 1.00000 1.219990e-08 1.00000 1.220000e-08 1.00000 1.239990e-08 1.00000 1.240000e-08 1.00000 1.259990e-08 1.00000 1.260000e-08 1.00000 1.279990e-08 1.00000 1.280000e-08 -1.00000 1.299990e-08 -1.00000 1.300000e-08 1.00000 1.319990e-08 1.00000 1.320000e-08 -1.00000 1.339990e-08 -1.00000 1.340000e-08 1.00000 1.359990e-08 1.00000 1.360000e-08 1.00000 1.379990e-08 1.00000 1.380000e-08 1.00000 1.399990e-08 1.00000 1.400000e-08 1.00000 1.419990e-08 1.00000 1.420000e-08 -1.00000 1.439990e-08 -1.00000 1.440000e-08 -1.00000 1.459990e-08 -1.00000 1.460000e-08 -1.00000 1.479990e-08 -1.00000 1.480000e-08 -1.00000 1.499990e-08 -1.00000 1.500000e-08 1.00000 1.519990e-08 1.00000 1.520000e-08 1.00000 1.539990e-08 1.00000 1.540000e-08 -1.00000 1.559990e-08 -1.00000 1.560000e-08 1.00000 1.579990e-08 1.00000 1.580000e-08 1.00000 1.599990e-08 1.00000 1.600000e-08 -1.00000 1.619990e-08 -1.00000 1.620000e-08 1.00000 1.639990e-08 1.00000 1.640000e-08 1.00000 1.659990e-08 1.00000 1.660000e-08 -1.00000 1.679990e-08 -1.00000 1.680000e-08 -1.00000 1.699990e-08 -1.00000 1.700000e-08 1.00000 1.719990e-08 1.00000 1.720000e-08 1.00000 1.739990e-08 1.00000 1.740000e-08 1.00000 1.759990e-08 1.00000 1.760000e-08 -1.00000 1.779990e-08 -1.00000 1.780000e-08 1.00000 1.799990e-08 1.00000 1.800000e-08 -1.00000 1.819990e-08 -1.00000 1.820000e-08 -1.00000 1.839990e-08 -1.00000 1.840000e-08 1.00000 1.859990e-08 1.00000 1.860000e-08 -1.00000 1.879990e-08 -1.00000 1.880000e-08 -1.00000 1.899990e-08 -1.00000 1.900000e-08 1.00000 1.919990e-08 1.00000 1.920000e-08 1.00000 1.939990e-08 1.00000 1.940000e-08 -1.00000 1.959990e-08 -1.00000 1.960000e-08 -1.00000 1.979990e-08 -1.00000 1.980000e-08 -1.00000 1.999990e-08 -1.00000 2.000000e-08 1.00000 2.019990e-08 1.00000 2.020000e-08 -1.00000 2.039990e-08 -1.00000 2.040000e-08 1.00000 2.059990e-08 1.00000 2.060000e-08 -1.00000 2.079990e-08 -1.00000 2.080000e-08 -1.00000 2.099990e-08 -1.00000 2.100000e-08 1.00000 2.119990e-08 1.00000 2.120000e-08 1.00000 2.139990e-08 1.00000 2.140000e-08 -1.00000 2.159990e-08 -1.00000 2.160000e-08 -1.00000 2.179990e-08 -1.00000 2.180000e-08 1.00000 2.199990e-08 1.00000 2.200000e-08 -1.00000 2.219990e-08 -1.00000 2.220000e-08 1.00000 2.239990e-08 1.00000 2.240000e-08 -1.00000 2.259990e-08 -1.00000 2.260000e-08 1.00000 2.279990e-08 1.00000 2.280000e-08 -1.00000 2.299990e-08 -1.00000 2.300000e-08 1.00000 2.319990e-08 1.00000 2.320000e-08 1.00000 2.339990e-08 1.00000 2.340000e-08 1.00000 2.359990e-08 1.00000 2.360000e-08 -1.00000 2.379990e-08 -1.00000 2.380000e-08 1.00000 2.399990e-08 1.00000 2.400000e-08 -1.00000 2.419990e-08 -1.00000 2.420000e-08 1.00000 2.439990e-08 1.00000 2.440000e-08 -1.00000 2.459990e-08 -1.00000 2.460000e-08 1.00000 2.479990e-08 1.00000 2.480000e-08 -1.00000 2.499990e-08 -1.00000 2.500000e-08 1.00000 2.519990e-08 1.00000 2.520000e-08 -1.00000 2.539990e-08 -1.00000 2.540000e-08 1.00000 2.559990e-08 1.00000)
* received signal = main cursor + first post-cursor (the ISI to cancel)
Erx rxn 0 poly(2) nb 0 nbd 0 0 -0.505171 -0.07753
* 1-tap DFE: subtract tap * previous decision (summing node)
Eout outn 0 poly(2) rxn 0 nbd 0 0 1 0.07753
.end

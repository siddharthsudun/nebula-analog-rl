* CTLE  corner=tt vdd=1.8 temp=27.0C analysis=ac models=sky130
.temp 27.0
.param vdd=1.8
Vdd vdd 0 {vdd}
Vcm cm 0 1.296
Vinp inp cm AC 0.5 SIN(0 0.05 100e6)
Vinn inn cm AC -0.5 SIN(0 -0.05 100e6)
.lib "C:\Users\talk2.000\pdk\sky130A\libs.tech\ngspice\sky130.lib.spice" tt
XM1 outp inp sp 0 sky130_fd_pr__nfet_01v8 L=0.3921 W=55.7486 nf=1 m=1
XM2 outn inn sn 0 sky130_fd_pr__nfet_01v8 L=0.3921 W=55.7486 nf=1 m=1
Iref vdd nbias 0.00035613732784986495
XMref nbias nbias 0 0 sky130_fd_pr__nfet_01v8 L=2.0 W=56.9820 nf=1 m=1
XMtp sp nbias 0 0 sky130_fd_pr__nfet_01v8 L=2.0 W=56.9820 nf=1 m=1
XMtn sn nbias 0 0 sky130_fd_pr__nfet_01v8 L=2.0 W=56.9820 nf=1 m=1
Rs sp sn 3179.0758000564138
Cs sp sn 1.8162099438699198e-13
Rlp vdd outp 2450.2967834472656
Rln vdd outn 2450.2967834472656
Clp outp 0 3e-14
Cln outn 0 3e-14
.ac dec 50 1e6 10e9
.end
